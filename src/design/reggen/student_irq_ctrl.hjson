{
  name: "student_irq_ctrl"
  clock_primary: sys_clk
  bus_device: tlul
  bus_host: none
  available_input_list: []
  available_output_list: []
  regwidth: "32"
  registers:
  [
    {
      name: all_en
      desc: "0: suppresses all outgoing interrupt requests"
      swaccess: rw
      hwaccess: hro
      hwext: "false"
      hwqe : "false"
      fields:
      [
        {
          bits: 0
          name: "val"
          desc: ""
        }
      ]
    }
    {
      name: mask
      desc: "mask(n) = 1 <=> irq(n) enabled"
      swaccess: rw
      hwaccess: hrw
      hwext: "false"
      hwqe : "true"
      resval: "0xFFFFFFFF"
      fields:
      [
        {
          bits: 31:0
          name: "val"
          desc: ""
        }
      ]
    }
    {
      name: mask_set
      desc: "mask_set(n) = 1 <=> set bit n in mask"
      swaccess: wo
      hwaccess: hro
      hwext : "false"
      hwqe : "true"
      fields:
      [
        {
          bits: 31:0
          name: "val"
          desc: ""
        }
      ]
    }
    {
      name: mask_clr
      desc: "mask_clr(n) = 1 <=> clear bit n in mask"
      swaccess: wo
      hwaccess: hro
      hwext : "false"
      hwqe : "true"
      fields:
      [
        {
          bits: 31:0
          name: "val"
          desc: ""
        }
      ]
    }    
    {
      name: status
      desc: "status(n) = 1 <=> irq(n) is asserted"
      swaccess: ro
      hwaccess: hwo
      hwext: "true"
      hwqe : "false"
      fields:
      [
        {
          bits: 31:0
          name: "val"
          desc: ""
        }
      ]
    }
    {
      name: irq_no
      desc: "n < IRQ_MAX: irq_no = n, irq(n) = 1 and there is no m < n with irq(m) = 1 and mask(m) = 1. n = IRQ_MAX: no pending unmasked irq"
      swaccess: ro
      hwaccess: hwo
      hwext: "true"
      hwqe : "false"
      fields:
      [
        {
          bits: 31:0
          name: "val"
          desc: ""
        }
      ]
    }
    {
      name: test
      desc: "0: regular operation; 1: all irq inputs are wired to the test_irq register"
      swaccess: rw
      hwaccess: hro
      hwext: "false"
      hwqe : "false"
      fields:
      [
        {
          bits: 0
          name: "val"
          desc: ""
        }
      ]
    }
    {
      name: test_irq
      desc: "see test"
      swaccess: rw
      hwaccess: hro
      hwext: "false"
      hwqe : "false"
      fields:
      [
        {
          bits: 31:0
          name: "val"
          desc: ""
        }
      ]
    }
  ]
}