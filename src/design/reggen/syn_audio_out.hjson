{
  name: "syn_audio_out"
  clock_primary: sys_clk
  bus_device: tlul
  bus_host: none
  available_input_list: []
  available_output_list: []
  regwidth: "32"
  registers:
  [
    {
      name: test_audio_in
      desc: "sample currently being sent to audio codec"
      swaccess: rw
      fields:
      [
        {
          bits: 15:0
          name: "val"
          desc: ""
        }
      ]
    }
    {
      name: test_ready_strobe
      desc: "trigger next sample"
      swaccess: ro
      hwaccess: hrw
      hwext: "true"
      hwqe: "false"
      fields:
      [
        {
          bits: 0
          name: "val"
          desc: ""
        }
      ]
    }
    {
      name: lrclk
      desc: "lrclk generated by audio out"
      swaccess: ro
      hwaccess: hrw
      hwext: "true"
      hwqe: "false"
      fields:
      [
        {
          bits: 0
          name: "val"
          desc: ""
        }
      ]
    }
    {
      name: bclk
      desc: "bclk generated by audio out"
      swaccess: ro
      hwaccess: hrw
      hwext: "true"
      hwqe: "false"
      fields:
      [
        {
          bits: 0
          name: "val"
          desc: ""
        }
      ]
    }
    {
      name: sdata
      desc: "sdata generated by audio out"
      swaccess: ro
      hwaccess: hrw
      hwext: "true"
      hwqe: "false"
      fields:
      [
        {
          bits: 0
          name: "val"
          desc: ""
        }
      ]
    }
    {
      name: shift_reg
      desc: "Register where audio data is temporarily stored and serially shifted out. Last LSBs are padded with 0"
      swaccess: ro
      hwaccess: hrw
      hwext: "true"
      hwqe: "false"
      fields:
      [
        {
          bits: 23:0
          name: "val"
          desc: ""
        }
      ]
    }
  ]
}
